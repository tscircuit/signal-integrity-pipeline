Routed quasi-TEM coupled 2D extraction; JLC standard stackup (assumed)
.options klu reltol=1e-4 abstol=1e-9 vntol=1e-6 method=gear maxord=2 pivrel=0.1
VDECLARED0 n3 0 3.3
* General table-based IBIS LVC1G04_DCK; SHA-256 98640ca66b2d62ca2f4d9fbfdb37e8919f8960de2644085ec2d4441f31a9573c; converter 0.0.2
.subckt I0_IBIS_34f76af70fdeef846eef PAD0 REF0 REF1
VKU0 KU0 DIE1 PWL(0 0 2.5e-9 0 2.6e-9 0.1065625 2.7e-9 0.3884375 2.8e-9 0.78375 2.9e-9 1.0113125 3e-9 1.0979375 3.1e-9 1.11155 4e-9 1.104125)
VKD0 KD0 DIE1 PWL(0 1 2.5e-9 1 2.6e-9 0.9934375 2.7e-9 0.7115625 2.8e-9 0.31625 2.9e-9 0.0886875 3e-9 0.0020625 3.1e-9 -0.01155 4e-9 -0.004125)
XBUF0 PKGL0 DIE2 DIE1 DIE2 DIE1 KU0 KD0 I0_IBIS_34f76af70fdeef846eef_BUF0
RPKG0 PAD0 PKGR0 0.03
LPKG0 PKGR0 PKGL0 1.5000000000000002e-9
CPKG0a PAD0 DIE1 1.25e-13
CPKG0b PKGL0 DIE1 1.25e-13
RPKG1 REF0 PKGR1 0.03
LPKG1 PKGR1 PKGL1 1.5000000000000002e-9
VPDN1 DIE1 0 0
VPKG1 PKGL1 DIE1 0
CPKG1a REF0 DIE1 1.25e-13
CPKG1b PKGL1 DIE1 1.25e-13
RPKG2 REF1 PKGR2 0.03
LPKG2 PKGR2 PKGL2 1.5000000000000002e-9
VPDN2 DIE2 0 3.3
VPKG2 PKGL2 DIE2 0
CPKG2a REF1 DIE1 1.25e-13
CPKG2b PKGL2 DIE1 1.25e-13
.ends I0_IBIS_34f76af70fdeef846eef
* IBIS LVC1G04_OUT_33; typical; converter 0.0.2; package excluded
.subckt I0_IBIS_34f76af70fdeef846eef_BUF0 PAD PU_REF PD_REF PC_REF GC_REF KU KD
Ccomp PAD PD_REF 1.5e-12
Bpu PAD PU_REF I={V(KU,PD_REF)*pwl(min(max(V(PU_REF,PAD),-3.3),6.6),-3.3,0.08,0,0,6.6,-0.12)}
Bpd PAD PD_REF I={V(KD,PD_REF)*pwl(min(max(V(PAD,PD_REF),-3.3),6.6),-3.3,-0.08,0,0,6.6,0.12)}
Bpc PAD PC_REF I={pwl(min(max(V(PC_REF,PAD),-10),10),-10,0,10,0)}
Bgc PAD GC_REF I={pwl(min(max(V(PAD,GC_REF),-3.3),3.3),-3.3,-0.3,-0.6,0,3.3,0)}
.ends I0_IBIS_34f76af70fdeef846eef_BUF0

XIBIS0 n2 0 n3 I0_IBIS_34f76af70fdeef846eef
* General table-based IBIS LVC1G04_DCK; SHA-256 98640ca66b2d62ca2f4d9fbfdb37e8919f8960de2644085ec2d4441f31a9573c; converter 0.0.2
.subckt I1_IBIS_c3cba979745bd9a6a2c5 PAD0 REF0 REF1
XBUF0 PKGL0 DIE2 DIE1 DIE2 DIE1 I1_IBIS_c3cba979745bd9a6a2c5_BUF0
RPKG0 PAD0 PKGR0 0.03
LPKG0 PKGR0 PKGL0 1.5000000000000002e-9
CPKG0a PAD0 DIE1 1.25e-13
CPKG0b PKGL0 DIE1 1.25e-13
RPKG1 REF0 PKGR1 0.03
LPKG1 PKGR1 PKGL1 1.5000000000000002e-9
VPDN1 DIE1 0 0
VPKG1 PKGL1 DIE1 0
CPKG1a REF0 DIE1 1.25e-13
CPKG1b PKGL1 DIE1 1.25e-13
RPKG2 REF1 PKGR2 0.03
LPKG2 PKGR2 PKGL2 1.5000000000000002e-9
VPDN2 DIE2 0 3.3
VPKG2 PKGL2 DIE2 0
CPKG2a REF1 DIE1 1.25e-13
CPKG2b PKGL2 DIE1 1.25e-13
.ends I1_IBIS_c3cba979745bd9a6a2c5
* IBIS LVC1G04_IN_33; typical; converter 0.0.2; package excluded
.subckt I1_IBIS_c3cba979745bd9a6a2c5_BUF0 PAD PU_REF PD_REF PC_REF GC_REF
Ccomp PAD PD_REF 2e-12
Bpc PAD PC_REF I={pwl(min(max(V(PC_REF,PAD),-10),10),-10,0,10,0)}
Bgc PAD GC_REF I={pwl(min(max(V(PAD,GC_REF),-3.3),3.3),-3.3,-0.3,-0.6,0,3.3,0)}
.ends I1_IBIS_c3cba979745bd9a6a2c5_BUF0

XIBIS1 n6 0 n3 I1_IBIS_c3cba979745bd9a6a2c5
* General table-based IBIS LVC1G04_DCK; SHA-256 98640ca66b2d62ca2f4d9fbfdb37e8919f8960de2644085ec2d4441f31a9573c; converter 0.0.2
.subckt I2_IBIS_14e1993b4b47114fcf55 PAD0 REF0 REF1
VKU0 KU0 DIE1 PWL(0 0 4e-9 0)
VKD0 KD0 DIE1 PWL(0 1 4e-9 1)
XBUF0 PKGL0 DIE2 DIE1 DIE2 DIE1 KU0 KD0 I2_IBIS_14e1993b4b47114fcf55_BUF0
RPKG0 PAD0 PKGR0 0.03
LPKG0 PKGR0 PKGL0 1.5000000000000002e-9
CPKG0a PAD0 DIE1 1.25e-13
CPKG0b PKGL0 DIE1 1.25e-13
RPKG1 REF0 PKGR1 0.03
LPKG1 PKGR1 PKGL1 1.5000000000000002e-9
VPDN1 DIE1 0 0
VPKG1 PKGL1 DIE1 0
CPKG1a REF0 DIE1 1.25e-13
CPKG1b PKGL1 DIE1 1.25e-13
RPKG2 REF1 PKGR2 0.03
LPKG2 PKGR2 PKGL2 1.5000000000000002e-9
VPDN2 DIE2 0 3.3
VPKG2 PKGL2 DIE2 0
CPKG2a REF1 DIE1 1.25e-13
CPKG2b PKGL2 DIE1 1.25e-13
.ends I2_IBIS_14e1993b4b47114fcf55
* IBIS LVC1G04_OUT_33; typical; converter 0.0.2; package excluded
.subckt I2_IBIS_14e1993b4b47114fcf55_BUF0 PAD PU_REF PD_REF PC_REF GC_REF KU KD
Ccomp PAD PD_REF 1.5e-12
Bpu PAD PU_REF I={V(KU,PD_REF)*pwl(min(max(V(PU_REF,PAD),-3.3),6.6),-3.3,0.08,0,0,6.6,-0.12)}
Bpd PAD PD_REF I={V(KD,PD_REF)*pwl(min(max(V(PAD,PD_REF),-3.3),6.6),-3.3,-0.08,0,0,6.6,0.12)}
Bpc PAD PC_REF I={pwl(min(max(V(PC_REF,PAD),-10),10),-10,0,10,0)}
Bgc PAD GC_REF I={pwl(min(max(V(PAD,GC_REF),-3.3),3.3),-3.3,-0.3,-0.6,0,3.3,0)}
.ends I2_IBIS_14e1993b4b47114fcf55_BUF0

XIBIS2 n11 0 n3 I2_IBIS_14e1993b4b47114fcf55
* General table-based IBIS LVC1G04_DCK; SHA-256 98640ca66b2d62ca2f4d9fbfdb37e8919f8960de2644085ec2d4441f31a9573c; converter 0.0.2
.subckt I3_IBIS_a07221d9637d6a869e1c PAD0 REF0 REF1
XBUF0 PKGL0 DIE2 DIE1 DIE2 DIE1 I3_IBIS_a07221d9637d6a869e1c_BUF0
RPKG0 PAD0 PKGR0 0.03
LPKG0 PKGR0 PKGL0 1.5000000000000002e-9
CPKG0a PAD0 DIE1 1.25e-13
CPKG0b PKGL0 DIE1 1.25e-13
RPKG1 REF0 PKGR1 0.03
LPKG1 PKGR1 PKGL1 1.5000000000000002e-9
VPDN1 DIE1 0 0
VPKG1 PKGL1 DIE1 0
CPKG1a REF0 DIE1 1.25e-13
CPKG1b PKGL1 DIE1 1.25e-13
RPKG2 REF1 PKGR2 0.03
LPKG2 PKGR2 PKGL2 1.5000000000000002e-9
VPDN2 DIE2 0 3.3
VPKG2 PKGL2 DIE2 0
CPKG2a REF1 DIE1 1.25e-13
CPKG2b PKGL2 DIE1 1.25e-13
.ends I3_IBIS_a07221d9637d6a869e1c
* IBIS LVC1G04_IN_33; typical; converter 0.0.2; package excluded
.subckt I3_IBIS_a07221d9637d6a869e1c_BUF0 PAD PU_REF PD_REF PC_REF GC_REF
Ccomp PAD PD_REF 2e-12
Bpc PAD PC_REF I={pwl(min(max(V(PC_REF,PAD),-10),10),-10,0,10,0)}
Bgc PAD GC_REF I={pwl(min(max(V(PAD,GC_REF),-3.3),3.3),-3.3,-0.3,-0.6,0,3.3,0)}
.ends I3_IBIS_a07221d9637d6a869e1c_BUF0

XIBIS3 n14 0 n3 I3_IBIS_a07221d9637d6a869e1c
RARCD0 n2 ARCd0 0.0131362889984
RARCD1 route4 ARCd1 0.0131362889984
RARCD2 route5 ARCd2 0.0131362889984
RARCD3 n11 ARCd3 0.0131362889984
RARCD4 route6 ARCd4 0.0131362889984
RARCD5 route7 ARCd5 0.0131362889984
RARCQ00 ARCd0 ARCq0n0 0.00152985251808
RARCQ01 ARCd1 ARCq0n1 0.00152985251808
RARCQ02 ARCd2 ARCq0n2 0.00152985251808
RARCQ03 ARCd3 ARCq0n3 0.00152985251808
RARCQ04 ARCd4 ARCq0n4 0.00152985251808
RARCQ05 ARCd5 ARCq0n5 0.00152985251808
LARCQ00 ARCd0 ARCq0n0 2.84604649914e-11
LARCQ01 ARCd1 ARCq0n1 2.84604649914e-11
LARCQ02 ARCd2 ARCq0n2 2.84604649914e-11
LARCQ03 ARCd3 ARCq0n3 2.84604649914e-11
LARCQ04 ARCd4 ARCq0n4 2.84604649914e-11
LARCQ05 ARCd5 ARCq0n5 2.84604649914e-11
RARCQ10 ARCq0n0 ARCq1n0 0.00130638688266
RARCQ11 ARCq0n1 ARCq1n1 0.00130638688266
RARCQ12 ARCq0n2 ARCq1n2 0.00130638688266
RARCQ13 ARCq0n3 ARCq1n3 0.00130638688266
RARCQ14 ARCq0n4 ARCq1n4 0.00130638688266
RARCQ15 ARCq0n5 ARCq1n5 0.00130638688266
LARCQ10 ARCq0n0 ARCq1n0 1.6218454721e-11
LARCQ11 ARCq0n1 ARCq1n1 1.6218454721e-11
LARCQ12 ARCq0n2 ARCq1n2 1.6218454721e-11
LARCQ13 ARCq0n3 ARCq1n3 1.6218454721e-11
LARCQ14 ARCq0n4 ARCq1n4 1.6218454721e-11
LARCQ15 ARCq0n5 ARCq1n5 1.6218454721e-11
RARCQ20 ARCq1n0 ARCq2n0 0.00713359652798
RARCQ21 ARCq1n1 ARCq2n1 0.00713359652798
RARCQ22 ARCq1n2 ARCq2n2 0.00713359652798
RARCQ23 ARCq1n3 ARCq2n3 0.00713359652799
RARCQ24 ARCq1n4 ARCq2n4 0.00713359652799
RARCQ25 ARCq1n5 ARCq2n5 0.00713359652799
LARCQ20 ARCq1n0 ARCq2n0 4.15693490862e-11
LARCQ21 ARCq1n1 ARCq2n1 4.15693490862e-11
LARCQ22 ARCq1n2 ARCq2n2 4.15693490862e-11
LARCQ23 ARCq1n3 ARCq2n3 4.15693490862e-11
LARCQ24 ARCq1n4 ARCq2n4 4.15693490862e-11
LARCQ25 ARCq1n5 ARCq2n5 4.15693490862e-11
RARCQ30 ARCq2n0 ARCq3n0 0.0146480122069
RARCQ31 ARCq2n1 ARCq3n1 0.0146480122069
RARCQ32 ARCq2n2 ARCq3n2 0.0146480122069
RARCQ33 ARCq2n3 ARCq3n3 0.0146480122069
RARCQ34 ARCq2n4 ARCq3n4 0.0146480122069
RARCQ35 ARCq2n5 ARCq3n5 0.0146480122069
LARCQ30 ARCq2n0 ARCq3n0 3.04507009203e-11
LARCQ31 ARCq2n1 ARCq3n1 3.04507009203e-11
LARCQ32 ARCq2n2 ARCq3n2 3.04507009203e-11
LARCQ33 ARCq2n3 ARCq3n3 3.04507009204e-11
LARCQ34 ARCq2n4 ARCq3n4 3.04507009204e-11
LARCQ35 ARCq2n5 ARCq3n5 3.04507009204e-11
RARCQ40 ARCq3n0 ARCq4n0 0.029822853367
RARCQ41 ARCq3n1 ARCq4n1 0.029822853367
RARCQ42 ARCq3n2 ARCq4n2 0.029822853367
RARCQ43 ARCq3n3 ARCq4n3 0.029822853367
RARCQ44 ARCq3n4 ARCq4n4 0.029822853367
RARCQ45 ARCq3n5 ARCq4n5 0.029822853367
LARCQ40 ARCq3n0 ARCq4n0 1.94595218315e-11
LARCQ41 ARCq3n1 ARCq4n1 1.94595218315e-11
LARCQ42 ARCq3n2 ARCq4n2 1.94595218315e-11
LARCQ43 ARCq3n3 ARCq4n3 1.94595218315e-11
LARCQ44 ARCq3n4 ARCq4n4 1.94595218315e-11
LARCQ45 ARCq3n5 ARCq4n5 1.94595218315e-11
RARCQ50 ARCq4n0 ARCq5n0 0.0542920457336
RARCQ51 ARCq4n1 ARCq5n1 0.0542920457336
RARCQ52 ARCq4n2 ARCq5n2 0.0542920457336
RARCQ53 ARCq4n3 ARCq5n3 0.0542920457336
RARCQ54 ARCq4n4 ARCq5n4 0.0542920457336
RARCQ55 ARCq4n5 ARCq5n5 0.0542920457336
LARCQ50 ARCq4n0 ARCq5n0 1.06333310105e-11
LARCQ51 ARCq4n1 ARCq5n1 1.06333310105e-11
LARCQ52 ARCq4n2 ARCq5n2 1.06333310105e-11
LARCQ53 ARCq4n3 ARCq5n3 1.06333310105e-11
LARCQ54 ARCq4n4 ARCq5n4 1.06333310105e-11
LARCQ55 ARCq4n5 ARCq5n5 1.06333310105e-11
RARCQ60 ARCq5n0 ARCq6n0 0.108646847465
RARCQ61 ARCq5n1 ARCq6n1 0.108646847465
RARCQ62 ARCq5n2 ARCq6n2 0.108646847465
RARCQ63 ARCq5n3 ARCq6n3 0.108646847465
RARCQ64 ARCq5n4 ARCq6n4 0.108646847465
RARCQ65 ARCq5n5 ARCq6n5 0.108646847465
LARCQ60 ARCq5n0 ARCq6n0 6.29888708705e-12
LARCQ61 ARCq5n1 ARCq6n1 6.29888708705e-12
LARCQ62 ARCq5n2 ARCq6n2 6.29888708705e-12
LARCQ63 ARCq5n3 ARCq6n3 6.29888708705e-12
LARCQ64 ARCq5n4 ARCq6n4 6.29888708705e-12
LARCQ65 ARCq5n5 ARCq6n5 6.29888708705e-12
RARCQ70 ARCq6n0 ARCq7n0 0.109879844454
RARCQ71 ARCq6n1 ARCq7n1 0.109879844454
RARCQ72 ARCq6n2 ARCq7n2 0.109879844454
RARCQ73 ARCq6n3 ARCq7n3 0.109879844454
RARCQ74 ARCq6n4 ARCq7n4 0.109879844454
RARCQ75 ARCq6n5 ARCq7n5 0.109879844454
LARCQ70 ARCq6n0 ARCq7n0 1.87789803986e-12
LARCQ71 ARCq6n1 ARCq7n1 1.87789803986e-12
LARCQ72 ARCq6n2 ARCq7n2 1.87789803986e-12
LARCQ73 ARCq6n3 ARCq7n3 1.87789803986e-12
LARCQ74 ARCq6n4 ARCq7n4 1.87789803986e-12
LARCQ75 ARCq6n5 ARCq7n5 1.87789803986e-12
RARCQ80 ARCq7n0 ARCq8n0 0.981958338829
RARCQ81 ARCq7n1 ARCq8n1 0.981958338829
RARCQ82 ARCq7n2 ARCq8n2 0.981958338829
RARCQ83 ARCq7n3 ARCq8n3 0.981958338829
RARCQ84 ARCq7n4 ARCq8n4 0.981958338829
RARCQ85 ARCq7n5 ARCq8n5 0.981958338829
LARCQ80 ARCq7n0 ARCq8n0 4.94106006474e-12
LARCQ81 ARCq7n1 ARCq8n1 4.94106006474e-12
LARCQ82 ARCq7n2 ARCq8n2 4.94106006474e-12
LARCQ83 ARCq7n3 ARCq8n3 4.94106006474e-12
LARCQ84 ARCq7n4 ARCq8n4 4.94106006474e-12
LARCQ85 ARCq7n5 ARCq8n5 4.94106006474e-12
GARCSI0 ARCq8n0 ARCp8n0 ARCSx0 0 3696.51600401
GARCSV0 ARCSx0 0 ARCq8n0 ARCp8n0 -3696.51600401
GARCSF0 0 ARCSu0 ARCSx0 0 1
GARCS0_0 ARCSx0 0 ARCSu0 0 1
GARCS0_3 ARCSx0 0 ARCSu3 0 0.400677859815
RARCF0_0 ARCSu0 ARCF0_0 2062.69122094
LARCF0_0 ARCSu0 ARCF0_0 0.000184609629978
RARCF1_0 ARCF0_0 ARCF1_0 776.714172335
LARCF1_0 ARCF0_0 ARCF1_0 0.0000204565014608
RARCF2_0 ARCF1_0 ARCF2_0 2659.01593853
LARCF2_0 ARCF1_0 ARCF2_0 0.0000206082480089
RARCF3_0 ARCF2_0 ARCF3_0 4503.88375499
LARCF3_0 ARCF2_0 ARCF3_0 0.0000102720542531
RARCF4_0 ARCF3_0 ARCF4_0 8596.92825136
LARCF4_0 ARCF3_0 ARCF4_0 0.0000057698355318
RARCF5_0 ARCF4_0 ARCF5_0 15343.7021434
LARCF5_0 ARCF4_0 ARCF5_0 0.00000303040232758
RARCF6_0 ARCF5_0 ARCF6_0 30524.426656
LARCF6_0 ARCF5_0 ARCF6_0 0.00000177405731633
RARCF7_0 ARCF6_0 ARCF7_0 30817.0557123
LARCF7_0 ARCF6_0 ARCF7_0 5.27061477503e-7
RARCF8_0 ARCF7_0 0 275259.978717
LARCF8_0 ARCF7_0 0 0.00000138536178527
GARCSI1 ARCq8n1 ARCp8n1 ARCSx1 0 3696.51600401
GARCSV1 ARCSx1 0 ARCq8n1 ARCp8n1 -3696.51600401
GARCSF1 0 ARCSu1 ARCSx1 0 1
GARCS1_1 ARCSx1 0 ARCSu1 0 1
GARCS1_4 ARCSx1 0 ARCSu4 0 0.400677859815
RARCF0_1 ARCSu1 ARCF0_1 2062.69122094
LARCF0_1 ARCSu1 ARCF0_1 0.000184609629978
RARCF1_1 ARCF0_1 ARCF1_1 776.714172335
LARCF1_1 ARCF0_1 ARCF1_1 0.0000204565014608
RARCF2_1 ARCF1_1 ARCF2_1 2659.01593853
LARCF2_1 ARCF1_1 ARCF2_1 0.0000206082480089
RARCF3_1 ARCF2_1 ARCF3_1 4503.88375499
LARCF3_1 ARCF2_1 ARCF3_1 0.0000102720542531
RARCF4_1 ARCF3_1 ARCF4_1 8596.92825136
LARCF4_1 ARCF3_1 ARCF4_1 0.0000057698355318
RARCF5_1 ARCF4_1 ARCF5_1 15343.7021434
LARCF5_1 ARCF4_1 ARCF5_1 0.00000303040232758
RARCF6_1 ARCF5_1 ARCF6_1 30524.426656
LARCF6_1 ARCF5_1 ARCF6_1 0.00000177405731633
RARCF7_1 ARCF6_1 ARCF7_1 30817.0557123
LARCF7_1 ARCF6_1 ARCF7_1 5.27061477503e-7
RARCF8_1 ARCF7_1 0 275259.978717
LARCF8_1 ARCF7_1 0 0.00000138536178527
GARCSI2 ARCq8n2 ARCp8n2 ARCSx2 0 3696.51600401
GARCSV2 ARCSx2 0 ARCq8n2 ARCp8n2 -3696.51600401
GARCSF2 0 ARCSu2 ARCSx2 0 1
GARCS2_2 ARCSx2 0 ARCSu2 0 1
GARCS2_5 ARCSx2 0 ARCSu5 0 0.400677859815
RARCF0_2 ARCSu2 ARCF0_2 2062.69122094
LARCF0_2 ARCSu2 ARCF0_2 0.000184609629978
RARCF1_2 ARCF0_2 ARCF1_2 776.714172335
LARCF1_2 ARCF0_2 ARCF1_2 0.0000204565014608
RARCF2_2 ARCF1_2 ARCF2_2 2659.01593853
LARCF2_2 ARCF1_2 ARCF2_2 0.0000206082480089
RARCF3_2 ARCF2_2 ARCF3_2 4503.88375499
LARCF3_2 ARCF2_2 ARCF3_2 0.0000102720542531
RARCF4_2 ARCF3_2 ARCF4_2 8596.92825136
LARCF4_2 ARCF3_2 ARCF4_2 0.0000057698355318
RARCF5_2 ARCF4_2 ARCF5_2 15343.7021434
LARCF5_2 ARCF4_2 ARCF5_2 0.00000303040232758
RARCF6_2 ARCF5_2 ARCF6_2 30524.426656
LARCF6_2 ARCF5_2 ARCF6_2 0.00000177405731633
RARCF7_2 ARCF6_2 ARCF7_2 30817.0557123
LARCF7_2 ARCF6_2 ARCF7_2 5.27061477503e-7
RARCF8_2 ARCF7_2 0 275259.978717
LARCF8_2 ARCF7_2 0 0.00000138536178527
GARCSI3 ARCq8n3 ARCp8n3 ARCSx3 0 3696.516004
GARCSV3 ARCSx3 0 ARCq8n3 ARCp8n3 -3696.516004
GARCSF3 0 ARCSu3 ARCSx3 0 1
GARCS3_3 ARCSx3 0 ARCSu3 0 1
GARCS3_0 ARCSx3 0 ARCSu0 0 0.400677859815
RARCF0_3 ARCSu3 ARCF0_3 2062.69122094
LARCF0_3 ARCSu3 ARCF0_3 0.000184609629978
RARCF1_3 ARCF0_3 ARCF1_3 776.714172335
LARCF1_3 ARCF0_3 ARCF1_3 0.0000204565014608
RARCF2_3 ARCF1_3 ARCF2_3 2659.01593853
LARCF2_3 ARCF1_3 ARCF2_3 0.0000206082480089
RARCF3_3 ARCF2_3 ARCF3_3 4503.88375499
LARCF3_3 ARCF2_3 ARCF3_3 0.0000102720542531
RARCF4_3 ARCF3_3 ARCF4_3 8596.92825136
LARCF4_3 ARCF3_3 ARCF4_3 0.0000057698355318
RARCF5_3 ARCF4_3 ARCF5_3 15343.7021434
LARCF5_3 ARCF4_3 ARCF5_3 0.00000303040232758
RARCF6_3 ARCF5_3 ARCF6_3 30524.426656
LARCF6_3 ARCF5_3 ARCF6_3 0.00000177405731633
RARCF7_3 ARCF6_3 ARCF7_3 30817.0557123
LARCF7_3 ARCF6_3 ARCF7_3 5.27061477503e-7
RARCF8_3 ARCF7_3 0 275259.978717
LARCF8_3 ARCF7_3 0 0.00000138536178527
GARCSI4 ARCq8n4 ARCp8n4 ARCSx4 0 3696.516004
GARCSV4 ARCSx4 0 ARCq8n4 ARCp8n4 -3696.516004
GARCSF4 0 ARCSu4 ARCSx4 0 1
GARCS4_4 ARCSx4 0 ARCSu4 0 1
GARCS4_1 ARCSx4 0 ARCSu1 0 0.400677859815
RARCF0_4 ARCSu4 ARCF0_4 2062.69122094
LARCF0_4 ARCSu4 ARCF0_4 0.000184609629978
RARCF1_4 ARCF0_4 ARCF1_4 776.714172335
LARCF1_4 ARCF0_4 ARCF1_4 0.0000204565014608
RARCF2_4 ARCF1_4 ARCF2_4 2659.01593853
LARCF2_4 ARCF1_4 ARCF2_4 0.0000206082480089
RARCF3_4 ARCF2_4 ARCF3_4 4503.88375499
LARCF3_4 ARCF2_4 ARCF3_4 0.0000102720542531
RARCF4_4 ARCF3_4 ARCF4_4 8596.92825136
LARCF4_4 ARCF3_4 ARCF4_4 0.0000057698355318
RARCF5_4 ARCF4_4 ARCF5_4 15343.7021434
LARCF5_4 ARCF4_4 ARCF5_4 0.00000303040232758
RARCF6_4 ARCF5_4 ARCF6_4 30524.426656
LARCF6_4 ARCF5_4 ARCF6_4 0.00000177405731633
RARCF7_4 ARCF6_4 ARCF7_4 30817.0557123
LARCF7_4 ARCF6_4 ARCF7_4 5.27061477503e-7
RARCF8_4 ARCF7_4 0 275259.978717
LARCF8_4 ARCF7_4 0 0.00000138536178527
GARCSI5 ARCq8n5 ARCp8n5 ARCSx5 0 3696.516004
GARCSV5 ARCSx5 0 ARCq8n5 ARCp8n5 -3696.516004
GARCSF5 0 ARCSu5 ARCSx5 0 1
GARCS5_5 ARCSx5 0 ARCSu5 0 1
GARCS5_2 ARCSx5 0 ARCSu2 0 0.400677859815
RARCF0_5 ARCSu5 ARCF0_5 2062.69122094
LARCF0_5 ARCSu5 ARCF0_5 0.000184609629978
RARCF1_5 ARCF0_5 ARCF1_5 776.714172335
LARCF1_5 ARCF0_5 ARCF1_5 0.0000204565014608
RARCF2_5 ARCF1_5 ARCF2_5 2659.01593853
LARCF2_5 ARCF1_5 ARCF2_5 0.0000206082480089
RARCF3_5 ARCF2_5 ARCF3_5 4503.88375499
LARCF3_5 ARCF2_5 ARCF3_5 0.0000102720542531
RARCF4_5 ARCF3_5 ARCF4_5 8596.92825136
LARCF4_5 ARCF3_5 ARCF4_5 0.0000057698355318
RARCF5_5 ARCF4_5 ARCF5_5 15343.7021434
LARCF5_5 ARCF4_5 ARCF5_5 0.00000303040232758
RARCF6_5 ARCF5_5 ARCF6_5 30524.426656
LARCF6_5 ARCF5_5 ARCF6_5 0.00000177405731633
RARCF7_5 ARCF6_5 ARCF7_5 30817.0557123
LARCF7_5 ARCF6_5 ARCF7_5 5.27061477503e-7
RARCF8_5 ARCF7_5 0 275259.978717
LARCF8_5 ARCF7_5 0 0.00000138536178527
LARCL0 ARCp8n0 route4 2.31346324637e-9
LARCL1 ARCp8n1 route5 2.31346324637e-9
LARCL2 ARCp8n2 n6 2.31346324637e-9
LARCL3 ARCp8n3 route6 2.31346324637e-9
LARCL4 ARCp8n4 route7 2.31346324637e-9
LARCL5 ARCp8n5 n14 2.31346324637e-9
KARCL0_3 LARCL0 LARCL3 0.501274545939
KARCL1_4 LARCL1 LARCL4 0.501274545939
KARCL2_5 LARCL2 LARCL5 0.501274545939
CARCCS0 n2 0 3.28424386258e-14
CARCCS1 route4 0 6.56848772516e-14
CARCCS2 route5 0 6.56848772516e-14
CARCCS3 n6 0 3.28424386258e-14
CARCCS4 n11 0 3.28424386258e-14
CARCCS5 route6 0 6.56848772516e-14
CARCCS6 route7 0 6.56848772516e-14
CARCCS7 n14 0 3.28424386258e-14
CARCCS8 n2 n11 3.04081779546e-14
CARCCS9 route4 route6 6.08163559092e-14
CARCCS10 route5 route7 6.08163559092e-14
CARCCS11 n6 n14 3.04081779546e-14
CARCG0S0 n2 ARCG0S0c 7.59546530573e-16
RARCG0S0 ARCG0S0c 0 117832677.797
CARCG0S1 route4 ARCG0S1c 1.51909306115e-15
RARCG0S1 ARCG0S1c 0 58916338.8985
CARCG0S2 route5 ARCG0S2c 1.51909306115e-15
RARCG0S2 ARCG0S2c 0 58916338.8985
CARCG0S3 n6 ARCG0S3c 7.59546530573e-16
RARCG0S3 ARCG0S3c 0 117832677.797
CARCG0S4 n11 ARCG0S4c 7.59546530573e-16
RARCG0S4 ARCG0S4c 0 117832677.797
CARCG0S5 route6 ARCG0S5c 1.51909306115e-15
RARCG0S5 ARCG0S5c 0 58916338.8985
CARCG0S6 route7 ARCG0S6c 1.51909306115e-15
RARCG0S6 ARCG0S6c 0 58916338.8985
CARCG0S7 n14 ARCG0S7c 7.59546530573e-16
RARCG0S7 ARCG0S7c 0 117832677.797
CARCG0S8 n2 ARCG0S8c 7.51116154549e-16
RARCG0S8 ARCG0S8c n11 119155207.975
CARCG0S9 route4 ARCG0S9c 1.5022323091e-15
RARCG0S9 ARCG0S9c route6 59577603.9877
CARCG0S10 route5 ARCG0S10c 1.5022323091e-15
RARCG0S10 ARCG0S10c route7 59577603.9877
CARCG0S11 n6 ARCG0S11c 7.51116154549e-16
RARCG0S11 ARCG0S11c n14 119155207.975
CARCG1S0 n2 ARCG1S0c 4.61965050114e-16
RARCG1S0 ARCG1S0c 0 57011308.8218
CARCG1S1 route4 ARCG1S1c 9.23930100227e-16
RARCG1S1 ARCG1S1c 0 28505654.4109
CARCG1S2 route5 ARCG1S2c 9.23930100227e-16
RARCG1S2 ARCG1S2c 0 28505654.4109
CARCG1S3 n6 ARCG1S3c 4.61965050114e-16
RARCG1S3 ARCG1S3c 0 57011308.8218
CARCG1S4 n11 ARCG1S4c 4.61965050114e-16
RARCG1S4 ARCG1S4c 0 57011308.8218
CARCG1S5 route6 ARCG1S5c 9.23930100227e-16
RARCG1S5 ARCG1S5c 0 28505654.4109
CARCG1S6 route7 ARCG1S6c 9.23930100227e-16
RARCG1S6 ARCG1S6c 0 28505654.4109
CARCG1S7 n14 ARCG1S7c 4.61965050114e-16
RARCG1S7 ARCG1S7c 0 57011308.8218
CARCG1S8 n2 ARCG1S8c 4.56837597185e-16
RARCG1S8 ARCG1S8c n11 57651192.238
CARCG1S9 route4 ARCG1S9c 9.13675194371e-16
RARCG1S9 ARCG1S9c route6 28825596.119
CARCG1S10 route5 ARCG1S10c 9.13675194371e-16
RARCG1S10 ARCG1S10c route7 28825596.119
CARCG1S11 n6 ARCG1S11c 4.56837597185e-16
RARCG1S11 ARCG1S11c n14 57651192.238
CARCG2S0 n2 ARCG2S0c 4.813520726e-16
RARCG2S0 ARCG2S0c 0 16101164.4422
CARCG2S1 route4 ARCG2S1c 9.62704145201e-16
RARCG2S1 ARCG2S1c 0 8050582.2211
CARCG2S2 route5 ARCG2S2c 9.62704145201e-16
RARCG2S2 ARCG2S2c 0 8050582.2211
CARCG2S3 n6 ARCG2S3c 4.813520726e-16
RARCG2S3 ARCG2S3c 0 16101164.4422
CARCG2S4 n11 ARCG2S4c 4.813520726e-16
RARCG2S4 ARCG2S4c 0 16101164.4422
CARCG2S5 route6 ARCG2S5c 9.62704145201e-16
RARCG2S5 ARCG2S5c 0 8050582.2211
CARCG2S6 route7 ARCG2S6c 9.62704145201e-16
RARCG2S6 ARCG2S6c 0 8050582.2211
CARCG2S7 n14 ARCG2S7c 4.813520726e-16
RARCG2S7 ARCG2S7c 0 16101164.4422
CARCG2S8 n2 ARCG2S8c 4.76009438794e-16
RARCG2S8 ARCG2S8c n11 16281880.6601
CARCG2S9 route4 ARCG2S9c 9.52018877588e-16
RARCG2S9 ARCG2S9c route6 8140940.33007
CARCG2S10 route5 ARCG2S10c 9.52018877588e-16
RARCG2S10 ARCG2S10c route7 8140940.33007
CARCG2S11 n6 ARCG2S11c 4.76009438794e-16
RARCG2S11 ARCG2S11c n14 16281880.6601
CARCG3S0 n2 ARCG3S0c 4.85243759658e-16
RARCG3S0 ARCG3S0c 0 4700133.27378
CARCG3S1 route4 ARCG3S1c 9.70487519315e-16
RARCG3S1 ARCG3S1c 0 2350066.63689
CARCG3S2 route5 ARCG3S2c 9.70487519315e-16
RARCG3S2 ARCG3S2c 0 2350066.63689
CARCG3S3 n6 ARCG3S3c 4.85243759658e-16
RARCG3S3 ARCG3S3c 0 4700133.27378
CARCG3S4 n11 ARCG3S4c 4.85243759658e-16
RARCG3S4 ARCG3S4c 0 4700133.27378
CARCG3S5 route6 ARCG3S5c 9.70487519315e-16
RARCG3S5 ARCG3S5c 0 2350066.63689
CARCG3S6 route7 ARCG3S6c 9.70487519315e-16
RARCG3S6 ARCG3S6c 0 2350066.63689
CARCG3S7 n14 ARCG3S7c 4.85243759658e-16
RARCG3S7 ARCG3S7c 0 4700133.27378
CARCG3S8 n2 ARCG3S8c 4.7985793115e-16
RARCG3S8 ARCG3S8c n11 4752886.62041
CARCG3S9 route4 ARCG3S9c 9.597158623e-16
RARCG3S9 ARCG3S9c route6 2376443.3102
CARCG3S10 route5 ARCG3S10c 9.597158623e-16
RARCG3S10 ARCG3S10c route7 2376443.3102
CARCG3S11 n6 ARCG3S11c 4.7985793115e-16
RARCG3S11 ARCG3S11c n14 4752886.62041
CARCG4S0 n2 ARCG4S0c 4.8233260138e-16
RARCG4S0 ARCG4S0c 0 1391468.93271
CARCG4S1 route4 ARCG4S1c 9.6466520276e-16
RARCG4S1 ARCG4S1c 0 695734.466353
CARCG4S2 route5 ARCG4S2c 9.6466520276e-16
RARCG4S2 ARCG4S2c 0 695734.466353
CARCG4S3 n6 ARCG4S3c 4.8233260138e-16
RARCG4S3 ARCG4S3c 0 1391468.93271
CARCG4S4 n11 ARCG4S4c 4.8233260138e-16
RARCG4S4 ARCG4S4c 0 1391468.93271
CARCG4S5 route6 ARCG4S5c 9.6466520276e-16
RARCG4S5 ARCG4S5c 0 695734.466353
CARCG4S6 route7 ARCG4S6c 9.6466520276e-16
RARCG4S6 ARCG4S6c 0 695734.466353
CARCG4S7 n14 ARCG4S7c 4.8233260138e-16
RARCG4S7 ARCG4S7c 0 1391468.93271
CARCG4S8 n2 ARCG4S8c 4.76979084466e-16
RARCG4S8 ARCG4S8c n11 1407086.49899
CARCG4S9 route4 ARCG4S9c 9.53958168933e-16
RARCG4S9 ARCG4S9c route6 703543.249494
CARCG4S10 route5 ARCG4S10c 9.53958168933e-16
RARCG4S10 ARCG4S10c route7 703543.249494
CARCG4S11 n6 ARCG4S11c 4.76979084466e-16
RARCG4S11 ARCG4S11c n14 1407086.49899
CARCG5S0 n2 ARCG5S0c 4.85256800256e-16
RARCG5S0 ARCG5S0c 0 407003.83506
CARCG5S1 route4 ARCG5S1c 9.70513600511e-16
RARCG5S1 ARCG5S1c 0 203501.91753
CARCG5S2 route5 ARCG5S2c 9.70513600511e-16
RARCG5S2 ARCG5S2c 0 203501.91753
CARCG5S3 n6 ARCG5S3c 4.85256800256e-16
RARCG5S3 ARCG5S3c 0 407003.83506
CARCG5S4 n11 ARCG5S4c 4.85256800256e-16
RARCG5S4 ARCG5S4c 0 407003.83506
CARCG5S5 route6 ARCG5S5c 9.70513600511e-16
RARCG5S5 ARCG5S5c 0 203501.91753
CARCG5S6 route7 ARCG5S6c 9.70513600511e-16
RARCG5S6 ARCG5S6c 0 203501.91753
CARCG5S7 n14 ARCG5S7c 4.85256800256e-16
RARCG5S7 ARCG5S7c 0 407003.83506
CARCG5S8 n2 ARCG5S8c 4.79870827008e-16
RARCG5S8 ARCG5S8c n11 411571.963907
CARCG5S9 route4 ARCG5S9c 9.59741654015e-16
RARCG5S9 ARCG5S9c route6 205785.981953
CARCG5S10 route5 ARCG5S10c 9.59741654015e-16
RARCG5S10 ARCG5S10c route7 205785.981953
CARCG5S11 n6 ARCG5S11c 4.79870827008e-16
RARCG5S11 ARCG5S11c n14 411571.963907
CARCG6S0 n2 ARCG6S0c 4.81252094682e-16
RARCG6S0 ARCG6S0c 0 120766.783322
CARCG6S1 route4 ARCG6S1c 9.62504189363e-16
RARCG6S1 ARCG6S1c 0 60383.3916612
CARCG6S2 route5 ARCG6S2c 9.62504189363e-16
RARCG6S2 ARCG6S2c 0 60383.3916612
CARCG6S3 n6 ARCG6S3c 4.81252094682e-16
RARCG6S3 ARCG6S3c 0 120766.783322
CARCG6S4 n11 ARCG6S4c 4.81252094682e-16
RARCG6S4 ARCG6S4c 0 120766.783322
CARCG6S5 route6 ARCG6S5c 9.62504189364e-16
RARCG6S5 ARCG6S5c 0 60383.3916612
CARCG6S6 route7 ARCG6S6c 9.62504189363e-16
RARCG6S6 ARCG6S6c 0 60383.3916612
CARCG6S7 n14 ARCG6S7c 4.81252094682e-16
RARCG6S7 ARCG6S7c 0 120766.783322
CARCG6S8 n2 ARCG6S8c 4.75910570552e-16
RARCG6S8 ARCG6S8c n11 122122.245308
CARCG6S9 route4 ARCG6S9c 9.51821141105e-16
RARCG6S9 ARCG6S9c route6 61061.1226542
CARCG6S10 route5 ARCG6S10c 9.51821141105e-16
RARCG6S10 ARCG6S10c route7 61061.1226542
CARCG6S11 n6 ARCG6S11c 4.75910570552e-16
RARCG6S11 ARCG6S11c n14 122122.245308
CARCG7S0 n2 ARCG7S0c 4.6191164576e-16
RARCG7S0 ARCG7S0c 0 37026.3770859
CARCG7S1 route4 ARCG7S1c 9.23823291519e-16
RARCG7S1 ARCG7S1c 0 18513.1885429
CARCG7S2 route5 ARCG7S2c 9.23823291519e-16
RARCG7S2 ARCG7S2c 0 18513.1885429
CARCG7S3 n6 ARCG7S3c 4.6191164576e-16
RARCG7S3 ARCG7S3c 0 37026.3770859
CARCG7S4 n11 ARCG7S4c 4.6191164576e-16
RARCG7S4 ARCG7S4c 0 37026.3770859
CARCG7S5 route6 ARCG7S5c 9.23823291519e-16
RARCG7S5 ARCG7S5c 0 18513.1885429
CARCG7S6 route7 ARCG7S6c 9.23823291519e-16
RARCG7S6 ARCG7S6c 0 18513.1885429
CARCG7S7 n14 ARCG7S7c 4.6191164576e-16
RARCG7S7 ARCG7S7c 0 37026.3770859
CARCG7S8 n2 ARCG7S8c 4.56784785578e-16
RARCG7S8 ARCG7S8c n11 37441.9536645
CARCG7S9 route4 ARCG7S9c 9.13569571156e-16
RARCG7S9 ARCG7S9c route6 18720.9768322
CARCG7S10 route5 ARCG7S10c 9.13569571156e-16
RARCG7S10 ARCG7S10c route7 18720.9768322
CARCG7S11 n6 ARCG7S11c 4.56784785578e-16
RARCG7S11 ARCG7S11c n14 37441.9536645
CARCG8S0 n2 ARCG8S0c 7.61204549472e-16
RARCG8S0 ARCG8S0c 0 6611.78551013
CARCG8S1 route4 ARCG8S1c 1.52240909894e-15
RARCG8S1 ARCG8S1c 0 3305.89275507
CARCG8S2 route5 ARCG8S2c 1.52240909894e-15
RARCG8S2 ARCG8S2c 0 3305.89275507
CARCG8S3 n6 ARCG8S3c 7.61204549472e-16
RARCG8S3 ARCG8S3c 0 6611.78551013
CARCG8S4 n11 ARCG8S4c 7.61204549472e-16
RARCG8S4 ARCG8S4c 0 6611.78551013
CARCG8S5 route6 ARCG8S5c 1.52240909894e-15
RARCG8S5 ARCG8S5c 0 3305.89275507
CARCG8S6 route7 ARCG8S6c 1.52240909894e-15
RARCG8S6 ARCG8S6c 0 3305.89275507
CARCG8S7 n14 ARCG8S7c 7.61204549472e-16
RARCG8S7 ARCG8S7c 0 6611.78551013
CARCG8S8 n2 ARCG8S8c 7.52755770728e-16
RARCG8S8 ARCG8S8c n11 6685.99485539
CARCG8S9 route4 ARCG8S9c 1.50551154146e-15
RARCG8S9 ARCG8S9c route6 3342.99742769
CARCG8S10 route5 ARCG8S10c 1.50551154146e-15
RARCG8S10 ARCG8S10c route7 3342.99742769
CARCG8S11 n6 ARCG8S11c 7.52755770728e-16
RARCG8S11 ARCG8S11c n14 6685.99485539
CPAD0 n2 0 1.0373634494635473e-15
CPAD1 n6 0 1.0373634494635473e-15
CPAD2 n11 0 1.0373634494635473e-15
CPAD3 n14 0 1.0373634494635473e-15
RBIAS0 n2 0 1e9
RBIAS1 route4 0 1e9
RBIAS2 route5 0 1e9
RBIAS3 n6 0 1e9
RBIAS4 n11 0 1e9
RBIAS5 route6 0 1e9
RBIAS6 route7 0 1e9
RBIAS7 n14 0 1e9
RBIAS8 n3 0 1e9
.save v(n6) v(n14) v(n11) i(v.xibis0.vku0) i(v.xibis0.vkd0) i(v.xibis0.vpdn1) i(v.xibis0.vpkg1) i(v.xibis0.vpdn2) i(v.xibis0.vpkg2) i(v.xibis1.vpdn1) i(v.xibis1.vpkg1) i(v.xibis1.vpdn2) i(v.xibis1.vpkg2) i(v.xibis2.vku0) i(v.xibis2.vkd0) i(v.xibis2.vpdn1) i(v.xibis2.vpkg1) i(v.xibis2.vpdn2) i(v.xibis2.vpkg2) i(v.xibis3.vpdn1) i(v.xibis3.vpkg1) i(v.xibis3.vpdn2) i(v.xibis3.vpkg2)
.tran 1.5833333333333334e-11 4e-9 0 1.5833333333333334e-11
.end
